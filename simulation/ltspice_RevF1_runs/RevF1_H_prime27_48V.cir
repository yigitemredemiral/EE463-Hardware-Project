* Generated by LTspice 26.0.2 for Windows.
VaQ1 QD QDX 0
XQ1 QDX GH SW BSC040N08NS5_L0 ;pnba D)G)S
L1 SW LOUT 33u Rser=20m
C1 OUT 0 330u x2 Rser=20m Lser=3n
R1 FBOUT N005 140k
R2 N005 0 10k
C2 N001 SW 1u
C3 0 INTVCC 0.1u
C4 N008 0 27n Rser=8.2K Cpar=470p
C5 N007 0 22n
V1 SOURCE 0 {VIN}
VaQ2 SW SWX 0
XQ2 SWX GL 0 BSC026N08NS5_L0 ;pnba D)G)S
Rload OUT 0 R={if(TEST==1,table(time,0,RL,7m,RL,7.01m,RFAULT,10m,RFAULT,10.01m,RL),RL)}
R4 SENSEP OUT 4m
R3 N004 0 24.3k
C6 SENSEP OUT 1n
R5 N002 INTVCC 511K
R6 IN N003 825k
R7 N003 0 17.4k
XU1 N003 NC_01 SENSEP OUT N007 N005 N008 INTVCC MP_02 INTVCC N006 MP_03 0 N002 MP_04 MP_05 N004 INTVCC INTVCC TG SW N001 MP_06 BG MP_07 DRVCC MP_08 DRVCC MP_09 IN MP_10 OUT MP_11 RUN MP_12 INTVCC 0 INTVCC 0 LTC3895 ;pnba OVLO)Vprg)Sense+)Sense-)SS)Vfb)Ith)Mode))CPump_EN)CLKout))PLLIN)Pgood)))Freq)DRVset)DRVUV)TG)SW)Boost))BG))DRVcc))NDRV))Vin))EXTVcc))Run))PhaseMD)Ilim)INTVcc)GND
C7 0 DRVCC 4.7u
.param VIN=48 RL=2.4
.model BSC026N08NS5 VDMOS(Rg=1.9 Vto=3.0 Rd=20u Rs=412u Rb=1.37m Kp=70 Lambda=0.03 Cgdmin=29p Cgdmax=1.18n A=0.2 Cgs=4.9n Cjo=1.39n M=0.75 Is=49.5p VJ=2.5 N=1.12 TT=15n ksubthres=.1 mfg=Infineon Vds=80 Ron=2.6m Qg=74n)
Rsource SOURCE UNPROTECTED 50m
MRP CABLE GRP UNPROTECTED BSC026N08NS5
Bid UNPROTECTED GRP I=en_fw()*(max(ireg(),0)*0.5*(1-tanh((V(GRP,UNPROTECTED)-{VCLAMP})/0.1))+min(ireg(),0)) - (1-en_fw())*V(GRP,UNPROTECTED)/5
.func ireg() limit(0.2*(V(UNPROTECTED,CABLE)-0.02), -{IPUMP}, {IPUMP})
.func en_fw() 0.25*(1+tanh((V(UNPROTECTED)-3.9)/0.2))*(1+tanh((V(UNPROTECTED,CABLE)+0.011)/0.002))
RgLeak GRP UNPROTECTED 10Meg
Biq UNPROTECTED 0 I=80u*0.5*(1+tanh((V(UNPROTECTED)-3.9)/0.2))
.param IPUMP=11m VCLAMP=13
Lcable CABLE IN 200n Rser=5m
CinBulk IN 0 300u Rser=28m Lser=2.7n
CinCer IN 0 10u Rser=3m Lser=1n
Lloop IN QD 5n Rser=2m
Rtrace LOUT SENSEP 3m
RrunTop IN RUN 130k
RrunBot RUN 0 10k
RgH TG GHI 4.7
LgH GHI GH 5n Rser=10m
RgL BG GLI 2.2
LgL GLI GL 5n Rser=10m
RgsH GH SW 100k
RgsL GL 0 100k
.options plotwinsize=0 threads=1
.save V(OUT) V(IN) V(SOURCE) V(SW) V(GH) V(GL) V(DRVCC) V(QD) V(N008) V(N007) I(VaQ1) I(VaQ2) I(L1) I(V1) I(Rload)
* EE463 - Rev A / ELECTRICAL PROTOTYPE - NOT FOR FABRICATION
.lib models\LTC3895.sub
Chf QD 0 300n Rser=10m Lser=1n
Rsnub SW SNUB 2.2
Csnub SNUB 0 1n

* RevD: real auxiliary devices, supplied ONLY from controller INTVCC.
RcsP SENSEP CSP 100
RcsN OUT CSN 100
XCS CSN INTVCC 0 CS NC_CS CSP LT6105
RcsOut CS 0 2k
Ccs CS 0 10n
XREF 0 INTVCC VREF LT6654-1.25
Cref VREF 0 1u
RsetTop VREF ILIMREF 11.8k
RsetBot ILIMREF 0 12k
Rerr CS ERRN 20k
Cerr N008 ERRN 10n
RerrLeak N008 ERRN 10Meg
XEA ILIMREF ERRN INTVCC 0 CCOUT 0 LT1636
Riso CCOUT CLAMPK 150
Dclamp N008 CLAMPK BAT54
Caux INTVCC 0 1u
.lib models/LT6105.lib
.lib models/LT1636.lib
.lib models/LT6654-1.25.sub
.lib models/RevD_diodes.lib
.save V(CS) V(CCOUT) V(ILIMREF) V(INTVCC) I(MRP) V(GRP) V(UNPROTECTED) V(CABLE) I(Rsnub) V(N003) V(RUN)

.save I(CinBulk) I(CinCer) I(C1)

.param TEST=0 RFAULT=0.5
@LOOP OUT FBOUT fstart=500 fend=16k oct=1 delay=6m pp0=50m pp1=50m f0=1k f1=2k tsettle=1m tavgmin=2m nmax=1

Daux 0 INTVCC BAT54
.save V(SENSEP) V(N001) I(R4) I(Daux)

DvinClamp 0 IN BAT46WJ
.model BAT46WJ D(Is=.1703u N=1.06 Rs=1.3 Cjo=35p Vj=.4 M=.5 Eg=.69 XTI=2 Iave=.25 Vpk=100 mfg=NXP type=Schottky)
.save I(DvinClamp)

.save V(ERRN) V(CLAMPK) I(Riso) I(Dclamp)
.model BSC040N08NS5 VDMOS(Rg=1.1 Vto=3.0 Rd=31u Rs=634u Rb=2.11m Kp=40.6 Lambda=0.03 Cgdmin=17p Cgdmax=0.685n A=0.2 Cgs=2.84n Cjo=0.81n M=0.75 Is=28.7p VJ=2.5 N=1.12 TT=15n ksubthres=.1 mfg=Infineon_scaled_from_BSC026 Vds=80 Ron=4.0m Qg=43n)
.lib ../models/infineon/OptiMOS5/OptiMOS5_80V_LTSpice.lib
.options reltol=0.003 abstol=1e-9 vntol=1e-5 itl4=200 cshunt=1e-15
.save V(TG) V(BG) V(GHI) V(GLI) V(GH) V(GL)
Crun RUN 0 1n
* RevF1 generated by gen.py; 48 V prime chained from the 36 V prime (cold OP at 48 V did not converge)
.temp 27
.options method=gear
.loadstate "RevF1_H_prime27_36V.state"
.tran 0 12m 0 100n
.savestate "RevF1_H_prime27_48V.state"
.end
